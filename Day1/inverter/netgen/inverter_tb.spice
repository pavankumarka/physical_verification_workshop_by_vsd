** INVERTER_TB flat netlist
*.IPIN IN
*.OPIN OUT
*--------BEGIN_X1->INVERTER
*.IPIN IN
*.OPIN OUT
*.IOPIN VSS
*.IOPIN VDD
*--------BEGIN_X1_XM1->W'
XM1_X1 OUT NET1 GND GND X1_SKY130_FD_PR__NFET_01V8 X1_* X1_W/NF X1_* X1_0.29' X1_* X1_W/NF X1_* X1_0.29' X1_* X1_(W/NF X1_+ X1_0.29)'
+ X1_* X1_(W/NF X1_+ X1_0.29)' X1_/ X1_W' X1_/  W' L=0.18 W=4.5 NF=3 AD='INT((NF+1)/2) AS='INT((NF+2)/2) PD='2*INT((NF+1)/2)
+ PS='2*INT((NF+2)/2) NRD='0.29 NRS='0.29 SA=0 SB=0 SD=0 MULT=1 M=1
*--------END___X1_XM1->W'
*--------BEGIN_X1_XM2->W'
XM2_X1 OUT NET1 NET2 NET2 X1_SKY130_FD_PR__PFET_01V8 X1_* X1_W/NF X1_* X1_0.29' X1_* X1_W/NF X1_* X1_0.29' X1_* X1_(W/NF X1_+ X1_0.29)'
+ X1_* X1_(W/NF X1_+ X1_0.29)' X1_/ X1_W' X1_/  W' L=0.18 W=3 NF=3 AD='INT((NF+1)/2) AS='INT((NF+2)/2) PD='2*INT((NF+1)/2)
+ PS='2*INT((NF+2)/2) NRD='0.29 NRS='0.29 SA=0 SB=0 SD=0 MULT=1 M=1
*--------END___X1_XM2->W'
*--------END___X1->INVERTER
V1 NET1 GND PWL(0 0 20N 0 900N 1.8)
V2 NET2 GND 1.8
**** BEGIN USER ARCHITECTURE CODE

.LIB /USR/SHARE/PDK/SKY130A/LIBS.TECH/NGSPICE/SKY130.LIB.SPICE TT

.CONTROL
TRAN 1N 1U
PLOT V(IN) V(OUT)
.ENDC

**** END USER ARCHITECTURE CODE
.end
